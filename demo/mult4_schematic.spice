* Schematic of mult4 (4x4 multiplier), 338 transistors.
* Written from the layout's extracted netlist, so the transistors are in the layout's
* order with its sizes; the internal nets have plain names, and, as in any schematic,
* every p-transistor's body is tied to VDD and every n-transistor's to GND.
.subckt mult4 VDD GND A B C D E F G H R S T U V W X Y
M1 n1 n2 R GND nfet w=6u l=2u
M2 n3 n4 n5 GND nfet w=6u l=2u
M3 n6 n7 VDD VDD pfet w=6u l=2u
M4 GND n8 n9 GND nfet w=6u l=2u
M5 n10 n8 VDD VDD pfet w=6u l=2u
M6 VDD n5 n11 VDD pfet w=6u l=2u
M7 VDD A n12 VDD pfet w=6u l=2u
M8 GND n13 n14 GND nfet w=6u l=2u
M9 GND n15 n16 GND nfet w=6u l=2u
M10 VDD n7 n17 VDD pfet w=6u l=2u
M11 n18 n19 X GND nfet w=6u l=2u
M12 n20 n21 n22 VDD pfet w=6u l=2u
M13 VDD n23 n24 VDD pfet w=6u l=2u
M14 S R n25 GND nfet w=6u l=2u
M15 n26 n27 n28 VDD pfet w=6u l=2u
M16 VDD n29 n30 VDD pfet w=6u l=2u
M17 n31 n32 n6 VDD pfet w=6u l=2u
M18 VDD D n33 VDD pfet w=6u l=2u
M19 n34 n35 n36 GND nfet w=6u l=2u
M20 VDD n9 n37 VDD pfet w=6u l=2u
M21 n38 n27 n39 GND nfet w=6u l=2u
M22 n5 n15 n40 VDD pfet w=6u l=2u
M23 n41 A GND GND nfet w=6u l=2u
M24 n42 n43 T GND nfet w=6u l=2u
M25 n39 n29 n28 VDD pfet w=6u l=2u
M26 VDD C n44 VDD pfet w=6u l=2u
M27 n8 n45 n46 VDD pfet w=6u l=2u
M28 GND n7 n47 GND nfet w=6u l=2u
M29 n48 n49 GND GND nfet w=6u l=2u
M30 n50 n2 n51 VDD pfet w=6u l=2u
M31 VDD D n52 VDD pfet w=6u l=2u
M32 VDD A n35 VDD pfet w=6u l=2u
M33 n7 E n53 GND nfet w=6u l=2u
M34 n54 n55 VDD VDD pfet w=6u l=2u
M35 GND n56 n57 GND nfet w=6u l=2u
M36 n58 C GND GND nfet w=6u l=2u
M37 n59 n8 GND GND nfet w=6u l=2u
M38 n60 n21 n20 GND nfet w=6u l=2u
M39 VDD n34 n49 VDD pfet w=6u l=2u
M40 n29 n11 n61 VDD pfet w=6u l=2u
M41 VDD n55 n62 VDD pfet w=6u l=2u
M42 VDD C n63 VDD pfet w=6u l=2u
M43 n64 n43 VDD VDD pfet w=6u l=2u
M44 n28 n27 VDD VDD pfet w=6u l=2u
M45 n65 D GND GND nfet w=6u l=2u
M46 V n29 n54 VDD pfet w=6u l=2u
M47 R n39 n66 VDD pfet w=6u l=2u
M48 VDD n67 n68 VDD pfet w=6u l=2u
M49 VDD n63 n69 VDD pfet w=6u l=2u
M50 VDD C n70 VDD pfet w=6u l=2u
M51 n71 n72 n73 VDD pfet w=6u l=2u
M52 n74 n72 VDD VDD pfet w=6u l=2u
M53 GND n75 n76 GND nfet w=6u l=2u
M54 n77 n43 GND GND nfet w=6u l=2u
M55 GND n72 n77 GND nfet w=6u l=2u
M56 n17 n49 n78 VDD pfet w=6u l=2u
M57 VDD A n79 VDD pfet w=6u l=2u
M58 n80 n56 VDD VDD pfet w=6u l=2u
M59 n8 n45 GND GND nfet w=6u l=2u
M60 n81 n13 VDD VDD pfet w=6u l=2u
M61 n36 n9 GND GND nfet w=6u l=2u
M62 n6 n12 VDD VDD pfet w=6u l=2u
M63 n82 n83 n84 GND nfet w=6u l=2u
M64 n75 F n85 GND nfet w=6u l=2u
M65 VDD A n56 VDD pfet w=6u l=2u
M66 VDD n31 n67 VDD pfet w=6u l=2u
M67 n86 A GND GND nfet w=6u l=2u
M68 W n87 n24 VDD pfet w=6u l=2u
M69 n75 F VDD VDD pfet w=6u l=2u
M70 n88 n89 GND GND nfet w=6u l=2u
M71 n90 n89 n91 GND nfet w=6u l=2u
M72 n55 E n92 GND nfet w=6u l=2u
M73 n93 n11 GND GND nfet w=6u l=2u
M74 n94 n16 n27 VDD pfet w=6u l=2u
M75 VDD C n19 VDD pfet w=6u l=2u
M76 GND n55 n95 GND nfet w=6u l=2u
M77 n96 n13 n97 VDD pfet w=6u l=2u
M78 n98 n99 n83 VDD pfet w=6u l=2u
M79 n100 n23 n87 VDD pfet w=6u l=2u
M80 VDD n16 n101 VDD pfet w=6u l=2u
M81 n21 H n102 GND nfet w=6u l=2u
M82 n103 n12 n31 GND nfet w=6u l=2u
M83 n104 n29 GND GND nfet w=6u l=2u
M84 n105 C GND GND nfet w=6u l=2u
M85 n106 n70 n107 VDD pfet w=6u l=2u
M86 n40 n44 VDD VDD pfet w=6u l=2u
M87 GND n49 n108 GND nfet w=6u l=2u
M88 GND n32 n2 GND nfet w=6u l=2u
M89 n32 n12 n109 VDD pfet w=6u l=2u
M90 GND n67 n110 GND nfet w=6u l=2u
M91 n45 G VDD VDD pfet w=6u l=2u
M92 n111 n23 GND GND nfet w=6u l=2u
M93 n112 n23 n113 GND nfet w=6u l=2u
M94 n43 n29 n114 GND nfet w=6u l=2u
M95 n115 F n116 GND nfet w=6u l=2u
M96 n117 n118 GND GND nfet w=6u l=2u
M97 n27 n99 n119 GND nfet w=6u l=2u
M98 n120 n23 VDD VDD pfet w=6u l=2u
M99 n80 n39 VDD VDD pfet w=6u l=2u
M100 GND n115 n121 GND nfet w=6u l=2u
M101 GND n87 n89 GND nfet w=6u l=2u
M102 n83 n27 n122 GND nfet w=6u l=2u
M103 VDD n56 n123 VDD pfet w=6u l=2u
M104 n34 n35 n124 VDD pfet w=6u l=2u
M105 n122 n63 GND GND nfet w=6u l=2u
M106 GND n31 n125 GND nfet w=6u l=2u
M107 n126 n127 VDD VDD pfet w=6u l=2u
M108 n128 n13 n15 VDD pfet w=6u l=2u
M109 n66 n2 VDD VDD pfet w=6u l=2u
M110 n129 n35 n130 GND nfet w=6u l=2u
M111 GND n63 n131 GND nfet w=6u l=2u
M112 n25 n39 GND GND nfet w=6u l=2u
M113 GND n2 n25 GND nfet w=6u l=2u
M114 GND n9 n132 GND nfet w=6u l=2u
M115 n22 n70 n20 VDD pfet w=6u l=2u
M116 GND n34 n49 GND nfet w=6u l=2u
M117 n21 H VDD VDD pfet w=6u l=2u
M118 n106 n70 GND GND nfet w=6u l=2u
M119 GND n56 n133 GND nfet w=6u l=2u
M120 n134 n23 n135 VDD pfet w=6u l=2u
M121 n136 n43 n137 GND nfet w=6u l=2u
M122 n137 n72 GND GND nfet w=6u l=2u
M123 n45 G n138 GND nfet w=6u l=2u
M124 n127 n33 n139 VDD pfet w=6u l=2u
M125 VDD n75 n124 VDD pfet w=6u l=2u
M126 n15 n4 n140 GND nfet w=6u l=2u
M127 VDD n7 n141 VDD pfet w=6u l=2u
M128 n44 F VDD VDD pfet w=6u l=2u
M129 n142 n9 n143 VDD pfet w=6u l=2u
M130 n5 n15 n14 GND nfet w=6u l=2u
M131 n119 n16 GND GND nfet w=6u l=2u
M132 n109 n49 VDD VDD pfet w=6u l=2u
M133 n14 n44 GND GND nfet w=6u l=2u
M134 X n127 GND GND nfet w=6u l=2u
M135 n22 n106 VDD VDD pfet w=6u l=2u
M136 n7 E VDD VDD pfet w=6u l=2u
M137 GND n44 n144 GND nfet w=6u l=2u
M138 n30 n83 n82 VDD pfet w=6u l=2u
M139 n19 H n58 GND nfet w=6u l=2u
M140 n37 n75 VDD VDD pfet w=6u l=2u
M141 n43 n29 VDD VDD pfet w=6u l=2u
M142 n56 E n145 GND nfet w=6u l=2u
M143 GND n56 n1 GND nfet w=6u l=2u
M144 GND n70 n60 GND nfet w=6u l=2u
M145 VDD n82 U VDD pfet w=6u l=2u
M146 n122 n99 GND GND nfet w=6u l=2u
M147 n46 n79 VDD VDD pfet w=6u l=2u
M148 GND n63 n146 GND nfet w=6u l=2u
M149 GND n27 n72 GND nfet w=6u l=2u
M150 n70 G VDD VDD pfet w=6u l=2u
M151 n147 n39 S GND nfet w=6u l=2u
M152 n127 n33 GND GND nfet w=6u l=2u
M153 n140 n13 GND GND nfet w=6u l=2u
M154 n131 n16 n148 GND nfet w=6u l=2u
M155 GND n7 n48 GND nfet w=6u l=2u
M156 n51 n39 S VDD pfet w=6u l=2u
M157 n53 B GND GND nfet w=6u l=2u
M158 n149 n72 n42 GND nfet w=6u l=2u
M159 n47 n49 n32 GND nfet w=6u l=2u
M160 n61 n89 VDD VDD pfet w=6u l=2u
M161 R n39 n57 GND nfet w=6u l=2u
M162 n20 n106 GND GND nfet w=6u l=2u
M163 n115 F VDD VDD pfet w=6u l=2u
M164 n62 n89 n150 VDD pfet w=6u l=2u
M165 n10 n45 n59 VDD pfet w=6u l=2u
M166 n135 n118 W VDD pfet w=6u l=2u
M167 n55 E VDD VDD pfet w=6u l=2u
M168 n54 n11 VDD VDD pfet w=6u l=2u
M169 GND n82 U GND nfet w=6u l=2u
M170 VDD n31 n28 VDD pfet w=6u l=2u
M171 n12 F n151 GND nfet w=6u l=2u
M172 VDD n55 n152 VDD pfet w=6u l=2u
M173 n68 n72 n136 VDD pfet w=6u l=2u
M174 n14 n4 GND GND nfet w=6u l=2u
M175 n73 n43 T VDD pfet w=6u l=2u
M176 VDD n67 n74 VDD pfet w=6u l=2u
M177 n19 H VDD VDD pfet w=6u l=2u
M178 n52 H n153 GND nfet w=6u l=2u
M179 VDD n44 n96 VDD pfet w=6u l=2u
M180 GND n44 n154 GND nfet w=6u l=2u
M181 n57 n2 GND GND nfet w=6u l=2u
M182 n39 n31 n38 GND nfet w=6u l=2u
M183 GND n5 n11 GND nfet w=6u l=2u
M184 VDD n72 n64 VDD pfet w=6u l=2u
M185 n78 n12 n31 VDD pfet w=6u l=2u
M186 GND n79 n8 GND nfet w=6u l=2u
M187 VDD n44 n81 VDD pfet w=6u l=2u
M188 n144 n13 n3 GND nfet w=6u l=2u
M189 VDD n32 n2 VDD pfet w=6u l=2u
M190 VDD n49 n6 VDD pfet w=6u l=2u
M191 n70 G n105 GND nfet w=6u l=2u
M192 GND n75 n36 GND nfet w=6u l=2u
M193 n12 F VDD VDD pfet w=6u l=2u
M194 n85 B GND GND nfet w=6u l=2u
M195 n24 n118 VDD VDD pfet w=6u l=2u
M196 GND n55 n88 GND nfet w=6u l=2u
M197 VDD B n75 VDD pfet w=6u l=2u
M198 n76 n9 n34 GND nfet w=6u l=2u
M199 n33 G VDD VDD pfet w=6u l=2u
M200 n37 n35 VDD VDD pfet w=6u l=2u
M201 n92 D GND GND nfet w=6u l=2u
M202 GND n89 n93 GND nfet w=6u l=2u
M203 T n136 n77 GND nfet w=6u l=2u
M204 GND n45 n155 GND nfet w=6u l=2u
M205 n27 n99 n69 VDD pfet w=6u l=2u
M206 n79 H n41 GND nfet w=6u l=2u
M207 n97 n4 n5 VDD pfet w=6u l=2u
M208 n95 n89 n29 GND nfet w=6u l=2u
M209 n63 E n156 GND nfet w=6u l=2u
M210 n28 n83 n39 VDD pfet w=6u l=2u
M211 n83 n27 n101 VDD pfet w=6u l=2u
M212 n84 n29 n82 GND nfet w=6u l=2u
M213 n102 B GND GND nfet w=6u l=2u
M214 n91 n11 V GND nfet w=6u l=2u
M215 n101 n63 VDD VDD pfet w=6u l=2u
M216 n108 n7 GND GND nfet w=6u l=2u
M217 VDD n63 n157 VDD pfet w=6u l=2u
M218 n107 n21 VDD VDD pfet w=6u l=2u
M219 n24 n115 VDD VDD pfet w=6u l=2u
M220 GND n7 n158 GND nfet w=6u l=2u
M221 n52 H VDD VDD pfet w=6u l=2u
M222 n35 G VDD VDD pfet w=6u l=2u
M223 VDD n127 n23 VDD pfet w=6u l=2u
M224 VDD B n45 VDD pfet w=6u l=2u
M225 GND n115 n111 GND nfet w=6u l=2u
M226 n31 n32 n108 GND nfet w=6u l=2u
M227 n136 n43 n74 VDD pfet w=6u l=2u
M228 n40 n4 VDD VDD pfet w=6u l=2u
M229 n33 G n65 GND nfet w=6u l=2u
M230 VDD n59 n4 VDD pfet w=6u l=2u
M231 VDD n115 n120 VDD pfet w=6u l=2u
M232 n116 D GND GND nfet w=6u l=2u
M233 GND n23 n117 GND nfet w=6u l=2u
M234 n38 n83 n104 GND nfet w=6u l=2u
M235 T n136 n64 VDD pfet w=6u l=2u
M236 n84 n43 GND GND nfet w=6u l=2u
M237 n64 n67 VDD VDD pfet w=6u l=2u
M238 VDD n106 n13 VDD pfet w=6u l=2u
M239 n121 n23 n87 GND nfet w=6u l=2u
M240 n44 F n159 GND nfet w=6u l=2u
M241 n69 n16 VDD VDD pfet w=6u l=2u
M242 n123 n2 R VDD pfet w=6u l=2u
M243 VDD n75 n142 VDD pfet w=6u l=2u
M244 n113 n118 W GND nfet w=6u l=2u
M245 n77 n67 GND GND nfet w=6u l=2u
M246 VDD n56 n66 VDD pfet w=6u l=2u
M247 VDD n67 n71 VDD pfet w=6u l=2u
M248 n15 n4 n81 VDD pfet w=6u l=2u
M249 VDD n2 n80 VDD pfet w=6u l=2u
M250 n79 H VDD VDD pfet w=6u l=2u
M251 GND n52 Y GND nfet w=6u l=2u
M252 VDD n75 n160 VDD pfet w=6u l=2u
M253 n132 n75 GND GND nfet w=6u l=2u
M254 VDD B n21 VDD pfet w=6u l=2u
M255 GND n21 n106 GND nfet w=6u l=2u
M256 n126 n33 X VDD pfet w=6u l=2u
M257 GND n75 n161 GND nfet w=6u l=2u
M258 n93 n55 GND GND nfet w=6u l=2u
M259 n56 E VDD VDD pfet w=6u l=2u
M260 n35 G n86 GND nfet w=6u l=2u
M261 n130 n34 n132 GND nfet w=6u l=2u
M262 n29 n11 n88 GND nfet w=6u l=2u
M263 GND n55 n90 GND nfet w=6u l=2u
M264 n156 C GND GND nfet w=6u l=2u
M265 n101 n99 VDD VDD pfet w=6u l=2u
M266 GND n127 n23 GND nfet w=6u l=2u
M267 n138 B GND GND nfet w=6u l=2u
M268 VDD n20 n118 VDD pfet w=6u l=2u
M269 V n29 n93 GND nfet w=6u l=2u
M270 VDD n63 n94 VDD pfet w=6u l=2u
M271 n139 n19 VDD VDD pfet w=6u l=2u
M272 n143 n35 n130 VDD pfet w=6u l=2u
M273 n110 n72 n136 GND nfet w=6u l=2u
M274 VDD n27 n72 VDD pfet w=6u l=2u
M275 GND n59 n4 GND nfet w=6u l=2u
M276 GND n63 n119 GND nfet w=6u l=2u
M277 n157 n16 n98 VDD pfet w=6u l=2u
M278 GND n106 n13 GND nfet w=6u l=2u
M279 VDD n115 n100 VDD pfet w=6u l=2u
M280 VDD n7 n109 VDD pfet w=6u l=2u
M281 n158 n49 n103 GND nfet w=6u l=2u
M282 n114 n83 GND GND nfet w=6u l=2u
M283 VDD B n7 VDD pfet w=6u l=2u
M284 n82 n43 VDD VDD pfet w=6u l=2u
M285 n108 n12 GND GND nfet w=6u l=2u
M286 n141 n49 n32 VDD pfet w=6u l=2u
M287 n59 n79 n10 VDD pfet w=6u l=2u
M288 VDD n13 n40 VDD pfet w=6u l=2u
M289 VDD n83 n43 VDD pfet w=6u l=2u
M290 n117 n115 GND GND nfet w=6u l=2u
M291 GND n31 n67 GND nfet w=6u l=2u
M292 n145 A GND GND nfet w=6u l=2u
M293 GND n33 n18 GND nfet w=6u l=2u
M294 n39 n31 n26 VDD pfet w=6u l=2u
M295 VDD n52 Y VDD pfet w=6u l=2u
M296 n87 n118 n111 GND nfet w=6u l=2u
M297 GND n115 n112 GND nfet w=6u l=2u
M298 n159 C GND GND nfet w=6u l=2u
M299 n25 n56 GND GND nfet w=6u l=2u
M300 n146 n16 n27 GND nfet w=6u l=2u
M301 GND n20 n118 GND nfet w=6u l=2u
M302 n87 n118 n120 VDD pfet w=6u l=2u
M303 W n87 n117 GND nfet w=6u l=2u
M304 n125 n27 n39 GND nfet w=6u l=2u
M305 VDD n8 n9 VDD pfet w=6u l=2u
M306 n148 n99 n83 GND nfet w=6u l=2u
M307 S R n80 VDD pfet w=6u l=2u
M308 GND n19 n127 GND nfet w=6u l=2u
M309 VDD n87 n89 VDD pfet w=6u l=2u
M310 n160 n9 n34 VDD pfet w=6u l=2u
M311 GND n44 n140 GND nfet w=6u l=2u
M312 X n19 n126 VDD pfet w=6u l=2u
M313 GND n16 n122 GND nfet w=6u l=2u
M314 GND n67 n137 GND nfet w=6u l=2u
M315 VDD n44 n128 VDD pfet w=6u l=2u
M316 VDD n130 n99 VDD pfet w=6u l=2u
M317 n161 n9 n129 GND nfet w=6u l=2u
M318 VDD D n115 VDD pfet w=6u l=2u
M319 n32 n12 n48 GND nfet w=6u l=2u
M320 VDD n55 n61 VDD pfet w=6u l=2u
M321 VDD n56 n50 VDD pfet w=6u l=2u
M322 VDD n15 n16 VDD pfet w=6u l=2u
M323 n132 n35 GND GND nfet w=6u l=2u
M324 VDD D n55 VDD pfet w=6u l=2u
M325 VDD n89 n54 VDD pfet w=6u l=2u
M326 n133 n2 n147 GND nfet w=6u l=2u
M327 n155 n79 n59 GND nfet w=6u l=2u
M328 GND n130 n99 GND nfet w=6u l=2u
M329 n151 A GND GND nfet w=6u l=2u
M330 n152 n89 n29 VDD pfet w=6u l=2u
M331 n130 n34 n37 VDD pfet w=6u l=2u
M332 n63 E VDD VDD pfet w=6u l=2u
M333 n150 n11 V VDD pfet w=6u l=2u
M334 GND n67 n149 GND nfet w=6u l=2u
M335 n153 D GND GND nfet w=6u l=2u
M336 VDD n115 n134 VDD pfet w=6u l=2u
M337 n124 n9 VDD VDD pfet w=6u l=2u
M338 n154 n13 n15 GND nfet w=6u l=2u
.ends
