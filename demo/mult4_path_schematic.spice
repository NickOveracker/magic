* Schematic of mult4_path (4x4 multiplier, sized for speed), 338 transistors.
* Written from the layout's extracted netlist, so the transistors are in the layout's
* order with its sizes; the internal nets have plain names, and, as in any schematic,
* every p-transistor's body is tied to VDD and every n-transistor's to GND.
.subckt mult4_path VDD GND A B C D E F G H R S T U V W X Y
M1 n1 G n2 GND nfet w=8u l=2u
M2 n3 n4 VDD VDD pfet w=0.156m l=2u
M3 n5 n6 VDD VDD pfet w=0.149m l=2u
M4 n7 n8 n9 GND nfet w=0.111m l=2u
M5 VDD n10 n11 VDD pfet w=54u l=2u
M6 n12 n13 GND GND nfet w=8u l=2u
M7 GND n4 n14 GND nfet w=0.134m l=2u
M8 VDD n4 n15 VDD pfet w=0.156m l=2u
M9 n16 n17 GND GND nfet w=8u l=2u
M10 n18 n10 n19 VDD pfet w=82u l=2u
M11 GND n10 n20 GND nfet w=27u l=2u
M12 n21 n22 n23 GND nfet w=0.142m l=2u
M13 n24 n25 n5 VDD pfet w=0.149m l=2u
M14 n26 A GND GND nfet w=8u l=2u
M15 W n27 n28 VDD pfet w=16u l=2u
M16 GND n29 n30 GND nfet w=8u l=2u
M17 n6 E VDD VDD pfet w=8u l=2u
M18 n31 H VDD VDD pfet w=8u l=2u
M19 GND n31 n32 GND nfet w=4u l=2u
M20 n33 n34 n35 GND nfet w=12u l=2u
M21 n36 n37 VDD VDD pfet w=16u l=2u
M22 GND n6 n38 GND nfet w=34u l=2u
M23 GND n39 n40 GND nfet w=8u l=2u
M24 GND n17 n41 GND nfet w=8u l=2u
M25 n42 n34 n27 VDD pfet w=16u l=2u
M26 n4 E n43 GND nfet w=8u l=2u
M27 GND n44 n34 GND nfet w=4u l=2u
M28 GND n45 n46 GND nfet w=0.103m l=2u
M29 n47 n46 VDD VDD pfet w=0.156m l=2u
M30 n48 n49 n50 VDD pfet w=16u l=2u
M31 n51 C GND GND nfet w=8u l=2u
M32 GND n52 n53 GND nfet w=14u l=2u
M33 V n54 n36 VDD pfet w=16u l=2u
M34 VDD n55 n56 VDD pfet w=0.156m l=2u
M35 T n48 n57 VDD pfet w=16u l=2u
M36 VDD n27 n58 VDD pfet w=8u l=2u
M37 VDD n59 n60 VDD pfet w=0.156m l=2u
M38 VDD n61 n62 VDD pfet w=0.156m l=2u
M39 GND n61 n62 GND nfet w=80u l=2u
M40 n63 n23 S GND nfet w=12u l=2u
M41 n64 n29 VDD VDD pfet w=0.156m l=2u
M42 n65 n29 n66 VDD pfet w=24u l=2u
M43 n57 n13 VDD VDD pfet w=16u l=2u
M44 GND n32 n8 GND nfet w=4u l=2u
M45 n39 G VDD VDD pfet w=8u l=2u
M46 n67 n68 VDD VDD pfet w=19u l=2u
M47 n69 n68 n70 VDD pfet w=42u l=2u
M48 VDD n45 n46 VDD pfet w=0.156m l=2u
M49 GND n37 n71 GND nfet w=0.156m l=2u
M50 VDD D n17 VDD pfet w=8u l=2u
M51 n72 n58 n73 VDD pfet w=24u l=2u
M52 n74 n49 GND GND nfet w=8u l=2u
M53 n75 n34 VDD VDD pfet w=16u l=2u
M54 n76 n8 n45 GND nfet w=0.105m l=2u
M55 VDD n29 n77 VDD pfet w=16u l=2u
M56 n78 n79 GND GND nfet w=8u l=2u
M57 n3 n62 VDD VDD pfet w=0.156m l=2u
M58 n37 E VDD VDD pfet w=8u l=2u
M59 VDD n4 n80 VDD pfet w=0.156m l=2u
M60 VDD n17 n81 VDD pfet w=24u l=2u
M61 n15 n46 n82 VDD pfet w=0.156m l=2u
M62 n83 n49 T GND nfet w=12u l=2u
M63 GND n17 n84 GND nfet w=8u l=2u
M64 VDD n85 n86 VDD pfet w=0.156m l=2u
M65 n87 n88 n89 GND nfet w=0.112m l=2u
M66 n90 n91 n92 VDD pfet w=24u l=2u
M67 n5 n93 VDD VDD pfet w=0.149m l=2u
M68 GND n94 n95 GND nfet w=4u l=2u
M69 n22 n62 n14 GND nfet w=0.134m l=2u
M70 n49 n54 VDD VDD pfet w=8u l=2u
M71 GND n96 n44 GND nfet w=4u l=2u
M72 VDD n97 n10 VDD pfet w=21u l=2u
M73 n98 n62 GND GND nfet w=96u l=2u
M74 S R n30 GND nfet w=8u l=2u
M75 n39 G n99 GND nfet w=8u l=2u
M76 GND n1 n100 GND nfet w=21u l=2u
M77 n101 n102 GND GND nfet w=74u l=2u
M78 VDD A n93 VDD pfet w=8u l=2u
M79 n37 E n103 GND nfet w=8u l=2u
M80 VDD n104 U VDD pfet w=8u l=2u
M81 n35 n95 W GND nfet w=12u l=2u
M82 n31 H n105 GND nfet w=8u l=2u
M83 n32 n39 n106 VDD pfet w=16u l=2u
M84 GND n37 n107 GND nfet w=0.156m l=2u
M85 n108 G VDD VDD pfet w=8u l=2u
M86 n109 n102 VDD VDD pfet w=0.148m l=2u
M87 n53 n10 n110 GND nfet w=14u l=2u
M88 n24 n25 n111 GND nfet w=75u l=2u
M89 n27 n95 n41 GND nfet w=8u l=2u
M90 n112 n54 GND GND nfet w=0.142m l=2u
M91 n96 H VDD VDD pfet w=8u l=2u
M92 VDD C n59 VDD pfet w=8u l=2u
M93 n70 n97 VDD VDD pfet w=42u l=2u
M94 VDD n52 n113 VDD pfet w=28u l=2u
M95 GND n97 n10 GND nfet w=11u l=2u
M96 n55 E n114 GND nfet w=8u l=2u
M97 GND n24 n13 GND nfet w=4u l=2u
M98 n115 D GND GND nfet w=8u l=2u
M99 n116 n86 GND GND nfet w=8u l=2u
M100 VDD n37 n117 VDD pfet w=0.156m l=2u
M101 n118 B GND GND nfet w=8u l=2u
M102 S R n77 VDD pfet w=16u l=2u
M103 n119 n44 VDD VDD pfet w=16u l=2u
M104 R n23 n120 GND nfet w=87u l=2u
M105 GND n52 n121 GND nfet w=41u l=2u
M106 n54 n86 n71 GND nfet w=0.156m l=2u
M107 VDD n24 n122 VDD pfet w=0.156m l=2u
M108 n123 G VDD VDD pfet w=8u l=2u
M109 n124 n10 GND GND nfet w=14u l=2u
M110 n125 n58 n54 VDD pfet w=0.156m l=2u
M111 GND n4 n126 GND nfet w=0.145m l=2u
M112 GND n88 n111 GND nfet w=75u l=2u
M113 n74 n54 n104 GND nfet w=8u l=2u
M114 n108 G n127 GND nfet w=8u l=2u
M115 VDD n44 n34 VDD pfet w=8u l=2u
M116 n128 n39 n94 VDD pfet w=16u l=2u
M117 VDD B n1 VDD pfet w=8u l=2u
M118 GND n46 n98 GND nfet w=96u l=2u
M119 n129 n8 VDD VDD pfet w=0.156m l=2u
M120 GND n8 n101 GND nfet w=74u l=2u
M121 GND n59 n7 GND nfet w=0.111m l=2u
M122 GND n13 n130 GND nfet w=12u l=2u
M123 VDD n32 n8 VDD pfet w=8u l=2u
M124 n131 A GND GND nfet w=8u l=2u
M125 n116 n37 GND GND nfet w=8u l=2u
M126 VDD n25 n29 VDD pfet w=95u l=2u
M127 n44 n108 n132 VDD pfet w=16u l=2u
M128 GND n34 n16 GND nfet w=8u l=2u
M129 GND n4 n133 GND nfet w=0.134m l=2u
M130 GND n22 n91 GND nfet w=4u l=2u
M131 GND n24 n134 GND nfet w=95u l=2u
M132 VDD n6 n135 VDD pfet w=0.156m l=2u
M133 n69 n97 GND GND nfet w=11u l=2u
M134 VDD n52 n18 VDD pfet w=82u l=2u
M135 n136 n123 n61 GND nfet w=41u l=2u
M136 n137 H VDD VDD pfet w=8u l=2u
M137 n138 n62 n79 GND nfet w=0.145m l=2u
M138 n25 n93 n139 VDD pfet w=67u l=2u
M139 VDD n8 n109 VDD pfet w=0.148m l=2u
M140 GND n59 n140 GND nfet w=0.105m l=2u
M141 GND n85 n86 GND nfet w=0.156m l=2u
M142 n141 n58 n142 GND nfet w=12u l=2u
M143 n128 n32 VDD VDD pfet w=16u l=2u
M144 n123 G n143 GND nfet w=8u l=2u
M145 n52 F VDD VDD pfet w=8u l=2u
M146 n55 E VDD VDD pfet w=8u l=2u
M147 n144 n8 n145 VDD pfet w=0.156m l=2u
M148 VDD n54 n146 VDD pfet w=16u l=2u
M149 GND n25 n29 GND nfet w=48u l=2u
M150 n2 B GND GND nfet w=8u l=2u
M151 n147 C GND GND nfet w=8u l=2u
M152 n113 n10 n110 VDD pfet w=28u l=2u
M153 n12 n49 GND GND nfet w=8u l=2u
M154 n122 n79 n23 VDD pfet w=0.156m l=2u
M155 VDD n94 n95 VDD pfet w=8u l=2u
M156 n9 n102 n85 GND nfet w=0.111m l=2u
M157 n11 n52 VDD VDD pfet w=54u l=2u
M158 GND n137 Y GND nfet w=4u l=2u
M159 GND n6 n148 GND nfet w=34u l=2u
M160 GND n13 n149 GND nfet w=8u l=2u
M161 VDD n22 n91 VDD pfet w=8u l=2u
M162 n96 H n51 GND nfet w=8u l=2u
M163 n20 n52 GND GND nfet w=27u l=2u
M164 n150 n91 GND GND nfet w=8u l=2u
M165 n28 n95 VDD VDD pfet w=16u l=2u
M166 n19 n123 n61 VDD pfet w=82u l=2u
M167 n68 H VDD VDD pfet w=8u l=2u
M168 n30 n55 GND GND nfet w=8u l=2u
M169 VDD B n6 VDD pfet w=8u l=2u
M170 n97 n1 GND GND nfet w=5u l=2u
M171 VDD B n31 VDD pfet w=8u l=2u
M172 n54 n86 n117 VDD pfet w=0.156m l=2u
M173 GND n108 n151 GND nfet w=8u l=2u
M174 GND n55 n152 GND nfet w=87u l=2u
M175 n153 n10 VDD VDD pfet w=28u l=2u
M176 n120 n29 GND GND nfet w=87u l=2u
M177 n36 n86 VDD VDD pfet w=16u l=2u
M178 VDD n4 n47 VDD pfet w=0.156m l=2u
M179 n56 n29 R VDD pfet w=0.156m l=2u
M180 n60 n8 n45 VDD pfet w=0.156m l=2u
M181 n57 n49 VDD VDD pfet w=16u l=2u
M182 n28 n17 VDD VDD pfet w=16u l=2u
M183 n66 n23 S VDD pfet w=24u l=2u
M184 VDD n55 n64 VDD pfet w=0.156m l=2u
M185 n135 n88 n154 VDD pfet w=0.156m l=2u
M186 GND n6 n87 GND nfet w=0.112m l=2u
M187 n134 n22 n23 GND nfet w=95u l=2u
M188 VDD n13 n155 VDD pfet w=16u l=2u
M189 VDD n6 n156 VDD pfet w=67u l=2u
M190 n100 n68 n69 GND nfet w=21u l=2u
M191 n50 n91 VDD VDD pfet w=16u l=2u
M192 n139 n88 VDD VDD pfet w=67u l=2u
M193 n85 n45 n101 GND nfet w=74u l=2u
M194 n142 n86 V GND nfet w=12u l=2u
M195 n79 n22 n98 GND nfet w=96u l=2u
M196 GND n55 n157 GND nfet w=12u l=2u
M197 n45 n102 n140 GND nfet w=0.105m l=2u
M198 VDD n17 n75 VDD pfet w=16u l=2u
M199 W n27 n16 GND nfet w=8u l=2u
M200 n52 F n158 GND nfet w=8u l=2u
M201 n77 n55 VDD VDD pfet w=16u l=2u
M202 n137 H n159 GND nfet w=8u l=2u
M203 VDD n137 Y VDD pfet w=8u l=2u
M204 n81 n34 n160 VDD pfet w=24u l=2u
M205 VDD D n37 VDD pfet w=8u l=2u
M206 n80 n46 n22 VDD pfet w=0.156m l=2u
M207 n23 n24 n21 GND nfet w=0.142m l=2u
M208 n85 n45 n109 VDD pfet w=0.148m l=2u
M209 n148 n88 n25 GND nfet w=34u l=2u
M210 n84 n34 n27 GND nfet w=8u l=2u
M211 n73 n86 V VDD pfet w=24u l=2u
M212 n4 E VDD VDD pfet w=8u l=2u
M213 n82 n62 n79 VDD pfet w=0.156m l=2u
M214 n89 n93 n24 GND nfet w=0.112m l=2u
M215 n92 n49 T VDD pfet w=24u l=2u
M216 n104 n49 VDD VDD pfet w=8u l=2u
M217 n59 F VDD VDD pfet w=8u l=2u
M218 VDD n46 n3 VDD pfet w=0.156m l=2u
M219 n30 n23 GND GND nfet w=8u l=2u
M220 VDD n79 n49 VDD pfet w=8u l=2u
M221 VDD n88 n5 VDD pfet w=0.149m l=2u
M222 n11 n123 VDD VDD pfet w=54u l=2u
M223 n20 n123 GND GND nfet w=27u l=2u
M224 n103 D GND GND nfet w=8u l=2u
M225 n14 n46 GND GND nfet w=0.134m l=2u
M226 n68 H n26 GND nfet w=8u l=2u
M227 n151 n96 X GND nfet w=8u l=2u
M228 n23 n24 n161 VDD pfet w=0.156m l=2u
M229 n105 B GND GND nfet w=8u l=2u
M230 n106 n31 VDD VDD pfet w=16u l=2u
M231 GND n17 n33 GND nfet w=12u l=2u
M232 n107 n58 n54 GND nfet w=0.156m l=2u
M233 n38 n88 GND GND nfet w=34u l=2u
M234 n32 n39 GND GND nfet w=4u l=2u
M235 VDD D n108 VDD pfet w=8u l=2u
M236 n41 n34 GND GND nfet w=8u l=2u
M237 n110 n123 n124 GND nfet w=14u l=2u
M238 GND n69 n102 GND nfet w=62u l=2u
M239 VDD n17 n42 VDD pfet w=16u l=2u
M240 n77 n23 VDD VDD pfet w=16u l=2u
M241 n114 A GND GND nfet w=8u l=2u
M242 GND n58 n116 GND nfet w=8u l=2u
M243 n157 n29 n63 GND nfet w=12u l=2u
M244 n97 n1 n67 VDD pfet w=19u l=2u
M245 n21 n79 n112 GND nfet w=0.142m l=2u
M246 X n44 GND GND nfet w=4u l=2u
M247 n17 F VDD VDD pfet w=8u l=2u
M248 n160 n95 W VDD pfet w=24u l=2u
M249 n71 n58 GND GND nfet w=0.156m l=2u
M250 VDD n37 n72 VDD pfet w=24u l=2u
M251 n104 n79 n74 GND nfet w=8u l=2u
M252 n40 n31 n94 GND nfet w=8u l=2u
M253 VDD A n123 VDD pfet w=8u l=2u
M254 GND n52 n124 GND nfet w=14u l=2u
M255 n111 n6 GND GND nfet w=75u l=2u
M256 GND n104 U GND nfet w=4u l=2u
M257 n127 D GND GND nfet w=8u l=2u
M258 n27 n95 n75 VDD pfet w=16u l=2u
M259 GND n59 n76 GND nfet w=0.105m l=2u
M260 VDD C n4 VDD pfet w=8u l=2u
M261 n49 n54 n78 GND nfet w=8u l=2u
M262 n119 n108 X VDD pfet w=16u l=2u
M263 VDD n59 n144 VDD pfet w=0.156m l=2u
M264 n43 C GND GND nfet w=8u l=2u
M265 n59 F n147 GND nfet w=8u l=2u
M266 VDD n59 n129 VDD pfet w=0.156m l=2u
M267 n101 n59 GND GND nfet w=74u l=2u
M268 n98 n4 GND GND nfet w=96u l=2u
M269 n130 n91 n83 GND nfet w=12u l=2u
M270 VDD n13 n90 VDD pfet w=24u l=2u
M271 n132 n96 VDD VDD pfet w=16u l=2u
M272 VDD C n39 VDD pfet w=8u l=2u
M273 n133 n46 n22 GND nfet w=0.134m l=2u
M274 n44 n108 GND GND nfet w=4u l=2u
M275 n70 n1 n69 VDD pfet w=42u l=2u
M276 VDD n110 n88 VDD pfet w=45u l=2u
M277 n93 F VDD VDD pfet w=8u l=2u
M278 GND n110 n88 GND nfet w=23u l=2u
M279 VDD D n137 VDD pfet w=8u l=2u
M280 n109 n59 VDD VDD pfet w=0.148m l=2u
M281 n161 n22 n122 VDD pfet w=0.156m l=2u
M282 VDD B n52 VDD pfet w=8u l=2u
M283 n143 A GND GND nfet w=8u l=2u
M284 n145 n102 n85 VDD pfet w=0.156m l=2u
M285 n146 n79 n104 VDD pfet w=16u l=2u
M286 VDD A n55 VDD pfet w=8u l=2u
M287 VDD n24 n13 VDD pfet w=8u l=2u
M288 n94 n32 GND GND nfet w=4u l=2u
M289 n23 n54 n122 VDD pfet w=0.156m l=2u
M290 n110 n123 n153 VDD pfet w=28u l=2u
M291 n149 n91 n48 GND nfet w=8u l=2u
M292 VDD n34 n28 VDD pfet w=16u l=2u
M293 GND n13 n150 GND nfet w=8u l=2u
M294 VDD n69 n102 VDD pfet w=0.125m l=2u
M295 VDD A n68 VDD pfet w=8u l=2u
M296 n99 C GND GND nfet w=8u l=2u
M297 GND n91 n12 GND nfet w=8u l=2u
M298 GND n68 n97 GND nfet w=5u l=2u
M299 n17 F n115 GND nfet w=8u l=2u
M300 V n54 n116 GND nfet w=8u l=2u
M301 n117 n58 VDD VDD pfet w=0.156m l=2u
M302 n6 E n118 GND nfet w=8u l=2u
M303 n152 n29 R GND nfet w=87u l=2u
M304 X n96 n119 VDD pfet w=16u l=2u
M305 VDD n52 n153 VDD pfet w=28u l=2u
M306 GND n55 n120 GND nfet w=87u l=2u
M307 n122 n22 VDD VDD pfet w=0.156m l=2u
M308 VDD n37 n125 VDD pfet w=0.156m l=2u
M309 n111 n93 GND GND nfet w=75u l=2u
M310 VDD n58 n36 VDD pfet w=16u l=2u
M311 R n23 n64 VDD pfet w=0.156m l=2u
M312 VDD C n96 VDD pfet w=8u l=2u
M313 n1 G VDD VDD pfet w=8u l=2u
M314 n45 n102 n129 VDD pfet w=0.156m l=2u
M315 n154 n93 n24 VDD pfet w=0.156m l=2u
M316 n155 n91 n48 VDD pfet w=16u l=2u
M317 GND n27 n58 GND nfet w=4u l=2u
M318 n61 n110 n11 VDD pfet w=54u l=2u
M319 n93 F n131 GND nfet w=8u l=2u
M320 VDD n13 n50 VDD pfet w=16u l=2u
M321 VDD n6 n139 VDD pfet w=67u l=2u
M322 VDD n55 n65 VDD pfet w=24u l=2u
M323 n16 n95 GND GND nfet w=8u l=2u
M324 n158 B GND GND nfet w=8u l=2u
M325 n61 n110 n20 GND nfet w=27u l=2u
M326 VDD n91 n57 VDD pfet w=16u l=2u
M327 n159 D GND GND nfet w=8u l=2u
M328 n121 n10 n136 GND nfet w=41u l=2u
M329 n156 n88 n25 VDD pfet w=67u l=2u
M330 n140 n8 GND GND nfet w=0.105m l=2u
M331 GND n37 n141 GND nfet w=12u l=2u
M332 n126 n46 n138 GND nfet w=0.145m l=2u
M333 n22 n62 n47 VDD pfet w=0.156m l=2u
M334 n94 n31 n128 VDD pfet w=16u l=2u
M335 n79 n22 n3 VDD pfet w=0.156m l=2u
M336 n25 n93 n38 GND nfet w=34u l=2u
M337 n48 n49 n150 GND nfet w=8u l=2u
M338 T n48 n12 GND nfet w=8u l=2u
.ends
